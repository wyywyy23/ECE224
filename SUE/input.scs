// Design: test/test
simulator lang=spectre
global 0
parameters vds=5 vgs=5
include "$C5_PDK_PATH/models/spectre/amis500cxakxx/bip.scs" section=typ
include "$C5_PDK_PATH/models/spectre/amis500cxakxx/cap.scs" section=typ
include "$C5_PDK_PATH/models/spectre/amis500cxakxx/dio.scs" section=typ
include "$C5_PDK_PATH/models/spectre/amis500cxakxx/mos.scs" section=typ
include "$C5_PDK_PATH/models/spectre/amis500cxakxx/res.scs" section=typ
include "$CDS_WORKAREA/userSetup_$USER/c5/device_models.scs" section=Default
include "$CDS_WORKAREA/userSetup_$USER/c5/custom_model_libraries.spectre"

// test/test/schematic
M0 (net04 net1 0 0) enm w=5.0 l=0.6 m=(1)*(1) mult=(1)*(1) region=1 matchingLevel="LOW"
V1 (net04 0) vsource dc=vds type=dc
V0 (net1 0) vsource dc=vgs type=dc
simulatorOptions options temp=27
dc dc param=vds start=0 stop=5
save net04

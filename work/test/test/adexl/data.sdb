ADE simulation setup
Run mode: Single Run, Sweeps and Corners
Tests:
  test:test:1: test/test/schematic, simulator spectre
Global variables:
  vds = 5
  vgs = 5
